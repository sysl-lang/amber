A transistor switching an LED from a pulse at its base, a capacitor across it
V1 vcc 0 5
V2 in 0 PULSE(0 5 1m 10u 10u 2m 5m)
RB in b 4.7k
RL vcc a 220
D1 a c dred
VM c cq 0
CL cq 0 100n
Q1 cq b 0 q2n3904
.model q2n3904 NPN (IS=6.734f BF=416.4 BR=0.7371 VAF=74.03)
.model dred D (IS=1e-17 N=2 RS=2)
.tran 50u 5m
.control
option reltol=1e-6 abstol=1e-14 vntol=1e-9
tran 50u 5m 0 2u
linearize v(b) v(cq) i(vm)
wrdata switch_tran.data v(b) v(cq) i(vm)
.endc
.end
